* ============================================================
* LR4 aktiv crossover, 80 Hz - v4
* Fix: op-amp utan algebraisk sluten loop
* Styrningsnod (np) och utgångsnod (out) separerade via intern nod
* ============================================================

* Op-amp: tvåstegs implementation utan sluten loop
* Steg 1: maeter V(plus)-V(minus) utan last
* Steg 2: buffrar till utgangsnoden
* Styrnoden och utgangsnoden delar ALDRIG samma nod i E-källan
.subckt opamp plus minus out
* Steg 1: foerstaerkning, styrs av plus och minus (ej av out)
Ediff  vdiff  0    plus  minus  1
Eamp   vamp   0    vdiff 0      1e5
* Steg 2: buffert till utgangsnod (liten Rser for konvergens)
Rbuf   vamp   out  1
* Liten kapacitans for att ge pol och hjaelpa konvergens
Cout   out    0    1pF
.ends opamp

* ---- Insignal ----
Vin  in  0  DC 0  AC 1

* ---- Ingangsbouffert ----
R1   in    chin  1k
R2   chin  0     100k
Xbuf chin  buf   buf   opamp

* ============================================================
* HOEGPASS - 2x Sallen-Key
* C1=C2=100nF, Rgnd=14k, RQ=28k till op-amp-utgaang
* ============================================================

* HP sektion 1 (U2A)
C1   buf    n_h1a  100nF
C2   n_h1a  n_h1p  100nF
R11  n_h1p  0      14k
R3   n_h1a  hp_s1  28k
Xhp1 n_h1p  hp_s1  hp_s1  opamp

* HP sektion 2 (U2B)
C3   hp_s1  n_h2a  100nF
C4   n_h2a  n_h2p  100nF
R12  n_h2p  0      14k
R6   n_h2a  hp_s2  28k
Xhp2 n_h2p  hp_s2  hp_s2  opamp

* HP utgangsbouffert (U3A)
Xhpo hp_s2  hp_out hp_out  opamp

* ============================================================
* LAEGPASS - 2x Sallen-Key
* R=19.6k, Cgnd=68nF, CQ=150nF till op-amp-utgaang
* ============================================================

* LP sektion 1 (U4B)
R13  buf    n_l1a  19.6k
R14  n_l1a  n_l1p  19.6k
C6   n_l1p  0      68nF
C5   n_l1a  lp_s1  150nF
Xlp1 n_l1p  lp_s1  lp_s1  opamp

* LP sektion 2 (U4A)
R19  lp_s1  n_l2a  19.6k
R20  n_l2a  n_l2p  19.6k
C8   n_l2p  0      68nF
C7   n_l2a  lp_s2  150nF
Xlp2 n_l2p  lp_s2  lp_s2  opamp

* LP utgangsbouffert (U3B)
Xlpo lp_s2  lp_out lp_out  opamp

* ============================================================
* Summering: HP + LP
* Tvaa separata E-kaellor summerar utan sluten loop
* ============================================================
Esum1  n_sum1  0      hp_out  0  1.0
Esum2  sum     n_sum1 lp_out  0  1.0

* ============================================================
* Analys
* ============================================================
.control
  ac dec 200 10 2000

  let hp_db  = vdb(hp_out)
  let lp_db  = vdb(lp_out)
  let sum_db = vdb(sum)

  plot hp_db lp_db sum_db
+   ylimit -45 5
+   title 'LR4 80Hz - HP(rod), LP(bla), Summa(gul)'
+   xlabel 'Frekvens [Hz]'
+   ylabel 'Amplitud [dB]'

  echo "=== Kontrollvarden ==="
  meas ac hp_at80    find hp_db   at=80
  meas ac lp_at80    find lp_db   at=80
  meas ac sum_at40   find sum_db  at=40
  meas ac sum_at80   find sum_db  at=80
  meas ac sum_at160  find sum_db  at=160
  echo ""
  echo "Foervaenat: hp_at80 ~ -6 dB, lp_at80 ~ -6 dB"
  echo "Foervaenat: sum_at80 ~ +0.4 dB (LP Q=0.743)"
  echo "Foervaenat: sum_at40 och sum_at160 ~ 0 dB"

.endc

.end
